* S-CENTER trigger regulator - standalone check
* 12V trigger in -> 7805 -> 5V out -> 82R dummy load (stand-in for TV input)

.include models/LM7805.lib

* Trigger turns on once at t=0 and stays high (not a repeating pulse) -
* PW/PER are set far longer than .tran's stop time so it never falls back.
V1 12V_IN 0 PULSE(0 12 0 1u 1u 1 2)
Cin 12V_IN 0 330n
X1 12V_IN 0 5V_OUT LM7805
Cout 5V_OUT 0 100n
Rload 5V_OUT 0 82

.tran 10u 40m
.control
run
plot v(5V_OUT)
.endc
.end
